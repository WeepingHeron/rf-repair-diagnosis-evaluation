* Third-order Butterworth band-pass filter
* Ideal lumped components, 50 ohm ports, f0=100 MHz, FBW=10 percent.
* Derived from g1=1, g2=2, g3=1 low-pass prototype values.

VPORT1 in 0 DC 0 AC 1 portnum 1 z0 50
VPORT2 out 0 DC 0 AC 1 portnum 2 z0 50

* Series resonator derived from g1.
L1 in n1 795.774715n
C1 n1 mid 3.183098862p

* Parallel resonator derived from g2.
L2 mid 0 3.978873577n
C2 mid 0 636.619772p

* Series resonator derived from g3.
L3 mid n3 795.774715n
C3 n3 out 3.183098862p

.sp lin 1501 50meg 200meg
.end
